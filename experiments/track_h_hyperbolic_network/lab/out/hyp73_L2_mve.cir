* {7,3} L=2 minimal viable experiment: boundary rail driven by a step, C to ground at interior nodes
* nominal R=100000 C=1.00e-06 V0=3.3; node names n<id>; boundary nodes tied to node RAIL
Vstep RAIL 0 PULSE(0 3.3 10m 1u 1u 100 200)
R000 n0 n1 100000
R001 n0 n6 100000
R002 n0 n11 100000
R003 n1 n2 100000
R004 n1 n7 100000
R005 n2 n3 100000
R006 n2 n12 100000
R007 n3 n4 100000
R008 n3 n17 100000
R009 n4 n5 100000
R010 n4 n22 100000
R011 n5 n6 100000
R012 n5 n27 100000
R013 n6 n28 100000
R014 n7 n8 100000
R015 n7 n15 100000
R016 n8 n9 100000
R017 n8 RAIL 100000
R018 n9 n10 100000
R019 n9 RAIL 100000
R020 n10 n11 100000
R021 n10 RAIL 100000
R022 n11 n32 100000
R023 n12 n13 100000
R024 n12 n16 100000
R025 n13 n14 100000
R026 n13 RAIL 100000
R027 n14 n15 100000
R028 n14 RAIL 100000
R029 n15 RAIL 100000
R030 n16 n19 100000
R031 n16 RAIL 100000
R032 n17 n18 100000
R033 n17 n21 100000
R034 n18 n19 100000
R035 n18 RAIL 100000
R036 n19 RAIL 100000
R037 n20 n21 100000
R038 n20 n23 100000
R039 n20 RAIL 100000
R040 n21 RAIL 100000
R041 n22 n23 100000
R042 n22 n26 100000
R043 n23 RAIL 100000
R044 n24 n25 100000
R045 n24 n27 100000
R046 n24 RAIL 100000
R047 n25 n26 100000
R048 n25 RAIL 100000
R049 n26 RAIL 100000
R050 n27 n31 100000
R051 n28 n29 100000
R052 n28 n34 100000
R053 n29 n30 100000
R054 n29 RAIL 100000
R055 n30 n31 100000
R056 n30 RAIL 100000
R057 n31 RAIL 100000
R058 n32 n33 100000
R059 n32 RAIL 100000
R060 n33 n34 100000
R061 n33 RAIL 100000
R062 n34 RAIL 100000
C000 n0 0 1.000e-06
C001 n1 0 1.000e-06
C002 n2 0 1.000e-06
C003 n3 0 1.000e-06
C004 n4 0 1.000e-06
C005 n5 0 1.000e-06
C006 n6 0 1.000e-06
C007 n7 0 1.000e-06
C008 n8 0 1.000e-06
C009 n9 0 1.000e-06
C010 n10 0 1.000e-06
C011 n11 0 1.000e-06
C012 n12 0 1.000e-06
C013 n13 0 1.000e-06
C014 n14 0 1.000e-06
C015 n15 0 1.000e-06
C016 n16 0 1.000e-06
C017 n17 0 1.000e-06
C018 n18 0 1.000e-06
C019 n19 0 1.000e-06
C020 n20 0 1.000e-06
C021 n21 0 1.000e-06
C022 n22 0 1.000e-06
C023 n23 0 1.000e-06
C024 n24 0 1.000e-06
C025 n25 0 1.000e-06
C026 n26 0 1.000e-06
C027 n27 0 1.000e-06
C028 n28 0 1.000e-06
C029 n29 0 1.000e-06
C030 n30 0 1.000e-06
C031 n31 0 1.000e-06
C032 n32 0 1.000e-06
C033 n33 0 1.000e-06
C034 n34 0 1.000e-06
.tran 1m 8
.print tran v(n8) v(n7) v(n0)
.end
