* square R=6 minimal viable experiment: boundary rail driven by a step, C to ground at interior nodes
* nominal R=100000 C=1.00e-06 V0=3.3; node names n<id>; boundary nodes tied to node RAIL
Vstep RAIL 0 PULSE(0 3.3 10m 1u 1u 100 200)
R004 RAIL n10 100000
R006 RAIL n11 100000
R008 RAIL n12 100000
R010 RAIL n13 100000
R012 RAIL n14 100000
R016 RAIL n10 100000
R017 RAIL n19 100000
R018 n10 n11 100000
R019 n10 n20 100000
R020 n11 n12 100000
R021 n11 n21 100000
R022 n12 n13 100000
R023 n12 n22 100000
R024 n13 n14 100000
R025 n13 n23 100000
R026 n14 RAIL 100000
R027 n14 n24 100000
R029 RAIL n25 100000
R033 RAIL n19 100000
R034 RAIL n29 100000
R035 n19 n20 100000
R036 n19 n30 100000
R037 n20 n21 100000
R038 n20 n31 100000
R039 n21 n22 100000
R040 n21 n32 100000
R041 n22 n23 100000
R042 n22 n33 100000
R043 n23 n24 100000
R044 n23 n34 100000
R045 n24 n25 100000
R046 n24 n35 100000
R047 n25 RAIL 100000
R048 n25 n36 100000
R050 RAIL n37 100000
R052 RAIL n29 100000
R054 n29 n30 100000
R055 n29 n40 100000
R056 n30 n31 100000
R057 n30 n41 100000
R058 n31 n32 100000
R059 n31 n42 100000
R060 n32 n33 100000
R061 n32 n43 100000
R062 n33 n34 100000
R063 n33 n44 100000
R064 n34 n35 100000
R065 n34 n45 100000
R066 n35 n36 100000
R067 n35 n46 100000
R068 n36 n37 100000
R069 n36 n47 100000
R070 n37 RAIL 100000
R071 n37 n48 100000
R073 RAIL n40 100000
R075 n40 n41 100000
R076 n40 n52 100000
R077 n41 n42 100000
R078 n41 n53 100000
R079 n42 n43 100000
R080 n42 n54 100000
R081 n43 n44 100000
R082 n43 n55 100000
R083 n44 n45 100000
R084 n44 n56 100000
R085 n45 n46 100000
R086 n45 n57 100000
R087 n46 n47 100000
R088 n46 n58 100000
R089 n47 n48 100000
R090 n47 n59 100000
R091 n48 RAIL 100000
R092 n48 n60 100000
R095 RAIL n52 100000
R097 n52 n53 100000
R098 n52 n64 100000
R099 n53 n54 100000
R100 n53 n65 100000
R101 n54 n55 100000
R102 n54 n66 100000
R103 n55 n56 100000
R104 n55 n67 100000
R105 n56 n57 100000
R106 n56 n68 100000
R107 n57 n58 100000
R108 n57 n69 100000
R109 n58 n59 100000
R110 n58 n70 100000
R111 n59 n60 100000
R112 n59 n71 100000
R113 n60 RAIL 100000
R114 n60 n72 100000
R117 RAIL n64 100000
R119 n64 n65 100000
R120 n64 n75 100000
R121 n65 n66 100000
R122 n65 n76 100000
R123 n66 n67 100000
R124 n66 n77 100000
R125 n67 n68 100000
R126 n67 n78 100000
R127 n68 n69 100000
R128 n68 n79 100000
R129 n69 n70 100000
R130 n69 n80 100000
R131 n70 n71 100000
R132 n70 n81 100000
R133 n71 n72 100000
R134 n71 n82 100000
R135 n72 RAIL 100000
R136 n72 n83 100000
R138 RAIL n75 100000
R140 n75 n76 100000
R141 n75 RAIL 100000
R142 n76 n77 100000
R143 n76 n87 100000
R144 n77 n78 100000
R145 n77 n88 100000
R146 n78 n79 100000
R147 n78 n89 100000
R148 n79 n80 100000
R149 n79 n90 100000
R150 n80 n81 100000
R151 n80 n91 100000
R152 n81 n82 100000
R153 n81 n92 100000
R154 n82 n83 100000
R155 n82 n93 100000
R156 n83 RAIL 100000
R157 n83 RAIL 100000
R160 RAIL n87 100000
R162 n87 n88 100000
R163 n87 RAIL 100000
R164 n88 n89 100000
R165 n88 n98 100000
R166 n89 n90 100000
R167 n89 n99 100000
R168 n90 n91 100000
R169 n90 n100 100000
R170 n91 n92 100000
R171 n91 n101 100000
R172 n92 n93 100000
R173 n92 n102 100000
R174 n93 RAIL 100000
R175 n93 RAIL 100000
R179 RAIL n98 100000
R181 n98 n99 100000
R182 n98 RAIL 100000
R183 n99 n100 100000
R184 n99 RAIL 100000
R185 n100 n101 100000
R186 n100 RAIL 100000
R187 n101 n102 100000
R188 n101 RAIL 100000
R189 n102 RAIL 100000
R190 n102 RAIL 100000
C010 n10 0 1.000e-06
C011 n11 0 1.000e-06
C012 n12 0 1.000e-06
C013 n13 0 1.000e-06
C014 n14 0 1.000e-06
C019 n19 0 1.000e-06
C020 n20 0 1.000e-06
C021 n21 0 1.000e-06
C022 n22 0 1.000e-06
C023 n23 0 1.000e-06
C024 n24 0 1.000e-06
C025 n25 0 1.000e-06
C029 n29 0 1.000e-06
C030 n30 0 1.000e-06
C031 n31 0 1.000e-06
C032 n32 0 1.000e-06
C033 n33 0 1.000e-06
C034 n34 0 1.000e-06
C035 n35 0 1.000e-06
C036 n36 0 1.000e-06
C037 n37 0 1.000e-06
C040 n40 0 1.000e-06
C041 n41 0 1.000e-06
C042 n42 0 1.000e-06
C043 n43 0 1.000e-06
C044 n44 0 1.000e-06
C045 n45 0 1.000e-06
C046 n46 0 1.000e-06
C047 n47 0 1.000e-06
C048 n48 0 1.000e-06
C052 n52 0 1.000e-06
C053 n53 0 1.000e-06
C054 n54 0 1.000e-06
C055 n55 0 1.000e-06
C056 n56 0 1.000e-06
C057 n57 0 1.000e-06
C058 n58 0 1.000e-06
C059 n59 0 1.000e-06
C060 n60 0 1.000e-06
C064 n64 0 1.000e-06
C065 n65 0 1.000e-06
C066 n66 0 1.000e-06
C067 n67 0 1.000e-06
C068 n68 0 1.000e-06
C069 n69 0 1.000e-06
C070 n70 0 1.000e-06
C071 n71 0 1.000e-06
C072 n72 0 1.000e-06
C075 n75 0 1.000e-06
C076 n76 0 1.000e-06
C077 n77 0 1.000e-06
C078 n78 0 1.000e-06
C079 n79 0 1.000e-06
C080 n80 0 1.000e-06
C081 n81 0 1.000e-06
C082 n82 0 1.000e-06
C083 n83 0 1.000e-06
C087 n87 0 1.000e-06
C088 n88 0 1.000e-06
C089 n89 0 1.000e-06
C090 n90 0 1.000e-06
C091 n91 0 1.000e-06
C092 n92 0 1.000e-06
C093 n93 0 1.000e-06
C098 n98 0 1.000e-06
C099 n99 0 1.000e-06
C100 n100 0 1.000e-06
C101 n101 0 1.000e-06
C102 n102 0 1.000e-06
.tran 1m 8
.print tran v(n10) v(n20) v(n31)
.end
